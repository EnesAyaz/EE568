# Ansys Electronics Desktop project, version 2019.3
materials:
  vacuum: permittivity=1
  NdFe30: permittivity=1 permeability=1.044573 conductivity=625000 magnetic_coercivity{Magnitude=-838000A_per_meter DirComp1=1 DirComp2=0 DirComp3=0} lande_g_factor=2
  Magnet_N_NdFe30: CoordinateSystemType=Cylindrical permittivity=1 permeability=1.05 conductivity=625000 magnetic_coercivity{Magnitude=-970087.27A_per_meter DirComp1=1 DirComp2=0 DirComp3=0} lande_g_factor=2
  Magnet_S_NdFe31: CoordinateSystemType=Cylindrical permittivity=1 permeability=1.05 conductivity=625000 magnetic_coercivity{Magnitude=-970087.27A_per_meter DirComp1=-1 DirComp2=0 DirComp3=0} lande_g_factor=2
  iron: permeability=4000 conductivity=10300000
  copper: permeability=0.999991 conductivity=58000000

design Maxwell2DDesign1 (Maxwell 2D, Magnetostatic, XY geometry, model units mm)
geometry:
  rotor [iron] = circle(normal=Z, centre=(0mm, 0mm, 0mm), radius=100mm)
  magnet [Magnet_N_NdFe30] = circle(normal=Z, centre=(0mm, 0mm, 0mm), radius=104mm)
  rotor_1 = rotor.copy()
  magnet.subtract(rotor_1)
  coordinate_system RelativeCS1 = origin=(0mm, 0mm, 0mm) x=(cos(1.256) mm, sin(1.256) mm, 0mm) y=(-sin(1.256) mm, cos(1.256) mm, 0mm)
  magnet.split(plane=ZX, keep=PositiveOnly)
  magnet.split(plane=ZX, keep=NegativeOnly) in RelativeCS1
  magnet_1 [Magnet_S_NdFe31], magnet_2 [Magnet_N_NdFe30], magnet_3 [Magnet_S_NdFe31] = magnet.duplicate_around_axis(axis=Z, angle=90deg, total=4)
  Circle1 = circle(normal=Z, centre=(0mm, 0mm, 0mm), radius=105mm)
  stator_solid [iron] = circle(normal=Z, centre=(0mm, 0mm, 0mm), radius=120mm)
  stator_solid.subtract(Circle1)
  Polyline1 [non-model] = polyline(z=0mm, xy in mm: (104.5, 0) (6.3987795e-15, -104.5) (-104.5, -1.2797559e-14), AngularArc from point 0 over 3 centre=(0mm, 0mm, 0mm) angle=-180deg plane=XY)
  air [vacuum] = circle(normal=Z, centre=(0mm, 0mm, 0mm), radius=200mm)
  magnet_4 = magnet.copy()
  magnet_1_1 = magnet_1.copy()
  magnet_2_1 = magnet_2.copy()
  magnet_3_1 = magnet_3.copy()
  rotor_2 = rotor.copy()
  stator_solid_1 = stator_solid.copy()
  air.subtract(magnet_4, magnet_1_1, magnet_2_1, magnet_3_1, rotor_2, stator_solid_1)
boundaries and excitations:
  VectorPotential1: Vector Potential Edges=air.edge(1 of 1) Value=0
mesh:
  initial mesh: MeshMethod=AnsoftTAU
setups:
  Setup1: Magnetostatic MaximumPasses=10 MinimumPasses=2 MinimumConvergedPasses=1 PercentRefinement=30 PercentError=1 NonLinearResidual=0.0001
field calculator expressions:
  B_normal = B_Vector | 2D_Normal | Dot
reports:
  Calculator Expressions Plot 1: Mag_B vs Distance on Setup1 : LastAdaptive
  Calculator Expressions Plot 2: B_normal vs Distance on Setup1 : LastAdaptive
  Calculator Expressions Plot 3: B_normal vs Distance on Setup1 : LastAdaptive

design Maxwell2DDesign2 (Maxwell 2D, Transient, XY geometry, model units mm)
options: ComputeTransientInductance ModelDepth=1meter Multiplier=1
geometry:
  rotor [iron] = circle(normal=Z, centre=(0mm, 0mm, 0mm), radius=100mm)
  magnet [Magnet_N_NdFe30] = circle(normal=Z, centre=(0mm, 0mm, 0mm), radius=104mm)
  rotor_1 = rotor.copy()
  magnet.subtract(rotor_1)
  coordinate_system RelativeCS1 = origin=(0mm, 0mm, 0mm) x=(cos(1.256) mm, sin(1.256) mm, 0mm) y=(-sin(1.256) mm, cos(1.256) mm, 0mm)
  magnet.split(plane=ZX, keep=PositiveOnly)
  magnet.split(plane=ZX, keep=NegativeOnly) in RelativeCS1
  magnet_1 [Magnet_S_NdFe31], magnet_2 [Magnet_N_NdFe30], magnet_3 [Magnet_S_NdFe31] = magnet.duplicate_around_axis(axis=Z, angle=90deg, total=4)
  Circle1 = circle(normal=Z, centre=(0mm, 0mm, 0mm), radius=105mm)
  stator_solid [iron] = circle(normal=Z, centre=(0mm, 0mm, 0mm), radius=120mm)
  stator_solid.subtract(Circle1)
  Circle2 [vacuum] = circle(normal=Z, centre=(0mm, 0mm, 0mm), radius=350mm)
  magnet_4 = magnet.copy()
  magnet_1_1 = magnet_1.copy()
  magnet_2_1 = magnet_2.copy()
  magnet_3_1 = magnet_3.copy()
  rotor_2 = rotor.copy()
  stator_solid_1 = stator_solid.copy()
  Circle2.subtract(magnet_4, magnet_1_1, magnet_2_1, magnet_3_1, rotor_2, stator_solid_1)
mesh:
  initial mesh: MeshMethod=AnsoftTAU

design Maxwell2DDesign3 (Maxwell 2D, Transient, XY geometry, model units mm)
options: ComputeTransientInductance ModelDepth=1meter Multiplier=1
geometry:
  Circle1 [iron] = circle(normal=Z, centre=(0mm, 0mm, 0mm), radius=50mm)
  Circle2 [Magnet_N_NdFe30] = circle(normal=Z, centre=(0mm, 0mm, 0mm), radius=54mm)
  Circle1_1 = Circle1.copy()
  Circle2.subtract(Circle1_1)
  Circle2.split(plane=ZX, keep=PositiveOnly)
  coordinate_system RelativeCS2 = origin=(0mm, 0mm, 0mm) x=(cos(0.502) mm, sin(0.502) mm, 0mm) y=(-sin(0.502) mm, cos(0.502) mm, 0mm)
  Circle2.split(plane=ZX, keep=NegativeOnly) in RelativeCS2
  Circle2_1 [Magnet_S_NdFe31], Circle2_2 [Magnet_N_NdFe30], Circle2_3 [Magnet_S_NdFe31], Circle2_4 [Magnet_N_NdFe30], Circle2_5 [Magnet_S_NdFe31], Circle2_6 [Magnet_N_NdFe30], Circle2_7 [Magnet_S_NdFe31], Circle2_8 [Magnet_N_NdFe30], Circle2_9 [Magnet_S_NdFe31] = Circle2.duplicate_around_axis(axis=Z, angle=36deg, total=10)
  Rectangle1 [copper] = rectangle(corner=(0mm, 55mm, 0mm), x_size=14mm, y_size=50mm)
  Rectangle1_1..Rectangle1_11 [copper] = Rectangle1.duplicate_around_axis(axis=Z, angle=30deg, total=12)
  Circle4 [iron] = circle(normal=Z, centre=(0mm, 0mm, 0mm), radius=160mm)
  Rectangle1_12 = Rectangle1.copy()
  Rectangle1_1_1 = Rectangle1_1.copy()
  Rectangle1_10_1 = Rectangle1_10.copy()
  Rectangle1_11_1 = Rectangle1_11.copy()
  Rectangle1_2_1 = Rectangle1_2.copy()
  Rectangle1_3_1 = Rectangle1_3.copy()
  Rectangle1_4_1 = Rectangle1_4.copy()
  Rectangle1_5_1 = Rectangle1_5.copy()
  Rectangle1_6_1 = Rectangle1_6.copy()
  Rectangle1_7_1 = Rectangle1_7.copy()
  Rectangle1_8_1 = Rectangle1_8.copy()
  Rectangle1_9_1 = Rectangle1_9.copy()
  Circle4.subtract(Rectangle1_12, Rectangle1_1_1, Rectangle1_10_1, Rectangle1_11_1, Rectangle1_2_1, Rectangle1_3_1, Rectangle1_4_1, Rectangle1_5_1, Rectangle1_6_1, Rectangle1_7_1, Rectangle1_8_1, Rectangle1_9_1)
  Circle5 = circle(normal=Z, centre=(0mm, 0mm, 0mm), radius=55mm)
  Circle4.subtract(Circle5)
  Circle6 [vacuum] = circle(normal=Z, centre=(0mm, 0mm, 0mm), radius=350.14283mm)
  Circle1_2 = Circle1.copy()
  Circle2_10 = Circle2.copy()
  Circle2_1_1 = Circle2_1.copy()
  Circle2_2_1 = Circle2_2.copy()
  Circle2_3_1 = Circle2_3.copy()
  Circle2_4_1 = Circle2_4.copy()
  Circle2_5_1 = Circle2_5.copy()
  Circle2_6_1 = Circle2_6.copy()
  Circle2_7_1 = Circle2_7.copy()
  Circle2_8_1 = Circle2_8.copy()
  Circle2_9_1 = Circle2_9.copy()
  Circle4_1 = Circle4.copy()
  Rectangle1_13 = Rectangle1.copy()
  Rectangle1_1_2 = Rectangle1_1.copy()
  Rectangle1_10_2 = Rectangle1_10.copy()
  Rectangle1_11_2 = Rectangle1_11.copy()
  Rectangle1_2_2 = Rectangle1_2.copy()
  Rectangle1_3_2 = Rectangle1_3.copy()
  Rectangle1_4_2 = Rectangle1_4.copy()
  Rectangle1_5_2 = Rectangle1_5.copy()
  Rectangle1_6_2 = Rectangle1_6.copy()
  Rectangle1_7_2 = Rectangle1_7.copy()
  Rectangle1_8_2 = Rectangle1_8.copy()
  Rectangle1_9_2 = Rectangle1_9.copy()
  Circle6.subtract(Circle1_2, Circle2_10, Circle2_1_1, Circle2_2_1, Circle2_3_1, Circle2_4_1, Circle2_5_1, Circle2_6_1, Circle2_7_1, Circle2_8_1, Circle2_9_1, Circle4_1, Rectangle1_13, Rectangle1_1_2, Rectangle1_10_2, Rectangle1_11_2, Rectangle1_2_2, Rectangle1_3_2, Rectangle1_4_2, Rectangle1_5_2, Rectangle1_6_2, Rectangle1_7_2, Rectangle1_8_2, Rectangle1_9_2)
  Circle7 [vacuum] = circle(normal=Z, centre=(0mm, 0mm, 0mm), radius=54.5mm)
  Circle7_1 = Circle7.copy()
  Circle6.subtract(Circle7_1)
  Circle8 = circle(normal=Z, centre=(0mm, 0mm, 0mm), radius=57mm)
  Circle4.subtract(Circle8)
motion:
  MotionSetup1: Band Move_Type=Rotate Coordinate_System=Global Axis=Z Is_Positive=true InitPos=0deg Angular_Velocity=300rpm Objects=Circle7
  Moving1: Moving Objects=[Circle1, Circle2, Circle2_1..Circle2_9]
boundaries and excitations:
  VectorPotential1: Vector Potential Edges=Circle6.edge(1 of 1) Value=0
  A1_P: Coil Objects=Rectangle1 Conductor_number=472 Winding=phaseA PolarityType=Positive
  A1_N: Coil Objects=Rectangle1_11 Conductor_number=472 Winding=phaseA PolarityType=Negative
  B1_N: Coil Objects=Rectangle1_10 Conductor_number=472 Winding=phaseB PolarityType=Negative
  B1_P: Coil Objects=Rectangle1_9 Conductor_number=472 Winding=phaseB PolarityType=Positive
  C1_P: Coil Objects=Rectangle1_8 Conductor_number=472 Winding=phaseC PolarityType=Positive
  C1_N: Coil Objects=Rectangle1_7 Conductor_number=472 Winding=phaseC PolarityType=Negative
  A2_N: Coil Objects=Rectangle1_5 Conductor_number=472 Winding=phaseA PolarityType=Negative
  A2_P: Coil Objects=Rectangle1_6 Conductor_number=472 Winding=phaseA PolarityType=Positive
  B2_P: Coil Objects=Rectangle1_4 Conductor_number=472 Winding=phaseB PolarityType=Positive
  B2_N: Coil Objects=Rectangle1_3 Conductor_number=472 Winding=phaseB PolarityType=Negative
  C2_N: Coil Objects=Rectangle1_2 Conductor_number=472 Winding=phaseC PolarityType=Negative
  C2_P: Coil Objects=Rectangle1_1 Conductor_number=472 Winding=phaseC PolarityType=Positive
  phaseA: Winding Group Type=Current IsSolid=false Current=1.9*sin(2*pi*50*time) ParallelBranchesNum=1
  phaseB: Winding Group Type=Current IsSolid=false Current=1.9*sin(2*pi*50*time-2*pi/3) ParallelBranchesNum=1
  phaseC: Winding Group Type=Current IsSolid=false Current=1.9*sin(2*pi*50*time) ParallelBranchesNum=1
parameters:
  Torque1: Torque Coordinate_System=Global Is_Positive=true Objects=[Circle2_4, Circle2_3, Circle1, Circle2_2, Circle2_1, Circle2, Circle2_9, Circle2_8, Circle2_7, Circle2_6, Circle2_5]
mesh:
  initial mesh: MeshMethod=AnsoftTAU
setups:
  Setup1: Transient NonlinearSolverResidual=0.0001 StopTime=80ms TimeStep=200us SaveFieldsType="Every N Steps" N_Steps=10 Steps_From=0s Steps_To=80ms NumberSolveSteps=1 RangeStart=0s RangeEnd=0.1s InitialTimeStep=0.002s MinTimeStep=0.001s MaxTimeStep=0.003s TimeStepErrTolerance=0.0001
reports:
  Torque Plot 1: Moving1.LoadTorque vs Time on Setup1 : Transient
  Torque Plot 2: Torque1.Torque vs Time on Setup1 : Transient
  Position Plot 1: Moving1.Position vs Time on Setup1 : Transient
  Winding Plot 1: InputCurrent(phaseA), InducedVoltage(phaseA) vs Time on Setup1 : Transient
  Torque Plot 3: AvgTorque vs X on Setup1 : Transient
  Torque Plot 4: abs(Torque1.Torque) vs Moving1.Position on Setup1 : Transient
