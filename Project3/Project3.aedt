# Ansys Electronics Desktop project, version 2019.3
materials:
  vacuum: permittivity=1
  NdFe30: permittivity=1 permeability=1.044573 conductivity=625000 magnetic_coercivity{Magnitude=-838000A_per_meter DirComp1=1 DirComp2=0 DirComp3=0} lande_g_factor=2
  Magnet_N_NdFe30: CoordinateSystemType=Cylindrical permittivity=1 permeability=1.05 conductivity=625000 magnetic_coercivity{Magnitude=-970087.27A_per_meter DirComp1=1 DirComp2=0 DirComp3=0} lande_g_factor=2
  Magnet_S_NdFe31: CoordinateSystemType=Cylindrical permittivity=1 permeability=1.05 conductivity=625000 magnetic_coercivity{Magnitude=-970087.27A_per_meter DirComp1=-1 DirComp2=0 DirComp3=0} lande_g_factor=2
  iron: permeability=4000 conductivity=10300000

design Maxwell2DDesign1 (Maxwell 2D, Magnetostatic, XY geometry, model units mm)
geometry:
  rotor [iron] = circle(normal=Z, centre=(0mm, 0mm, 0mm), radius=100mm)
  magnet [Magnet_N_NdFe30] = circle(normal=Z, centre=(0mm, 0mm, 0mm), radius=104mm)
  rotor_1 = rotor.copy()
  magnet.subtract(rotor_1)
  coordinate_system RelativeCS1 = origin=(0mm, 0mm, 0mm) x=(cos(1.256) mm, sin(1.256) mm, 0mm) y=(-sin(1.256) mm, cos(1.256) mm, 0mm)
  magnet.split(plane=ZX, keep=PositiveOnly)
  magnet.split(plane=ZX, keep=NegativeOnly) in RelativeCS1
  magnet_1 [Magnet_S_NdFe31], magnet_2 [Magnet_N_NdFe30], magnet_3 [Magnet_S_NdFe31] = magnet.duplicate_around_axis(axis=Z, angle=90deg, total=4)
  Circle1 = circle(normal=Z, centre=(0mm, 0mm, 0mm), radius=105mm)
  stator_solid [iron] = circle(normal=Z, centre=(0mm, 0mm, 0mm), radius=120mm)
  stator_solid.subtract(Circle1)
  Polyline1 [non-model] = polyline(z=0mm, xy in mm: (104.5, 0) (6.3987795e-15, -104.5) (-104.5, -1.2797559e-14), AngularArc from point 0 over 3 centre=(0mm, 0mm, 0mm) angle=-180deg plane=XY)
  air [vacuum] = circle(normal=Z, centre=(0mm, 0mm, 0mm), radius=200mm)
  magnet_4 = magnet.copy()
  magnet_1_1 = magnet_1.copy()
  magnet_2_1 = magnet_2.copy()
  magnet_3_1 = magnet_3.copy()
  rotor_2 = rotor.copy()
  stator_solid_1 = stator_solid.copy()
  air.subtract(magnet_4, magnet_1_1, magnet_2_1, magnet_3_1, rotor_2, stator_solid_1)
boundaries and excitations:
  VectorPotential1: Vector Potential Edges=air.edge(1 of 1) Value=0
mesh:
  initial mesh: MeshMethod=AnsoftTAU
setups:
  Setup1: Magnetostatic MaximumPasses=10 MinimumPasses=2 MinimumConvergedPasses=1 PercentRefinement=30 PercentError=1 NonLinearResidual=0.0001
field calculator expressions:
  B_normal = B_Vector | 2D_Normal | Dot
reports:
  Calculator Expressions Plot 1: Mag_B vs Distance on Setup1 : LastAdaptive
  Calculator Expressions Plot 2: B_normal vs Distance on Setup1 : LastAdaptive
  Calculator Expressions Plot 3: B_normal vs Distance on Setup1 : LastAdaptive

design Maxwell2DDesign2 (Maxwell 2D, Transient, XY geometry, model units mm)
options: ComputeTransientInductance ModelDepth=1meter Multiplier=1
geometry:
  rotor [iron] = circle(normal=Z, centre=(0mm, 0mm, 0mm), radius=100mm)
  magnet [Magnet_N_NdFe30] = circle(normal=Z, centre=(0mm, 0mm, 0mm), radius=104mm)
  rotor_1 = rotor.copy()
  magnet.subtract(rotor_1)
  coordinate_system RelativeCS1 = origin=(0mm, 0mm, 0mm) x=(cos(1.256) mm, sin(1.256) mm, 0mm) y=(-sin(1.256) mm, cos(1.256) mm, 0mm)
  magnet.split(plane=ZX, keep=PositiveOnly)
  magnet.split(plane=ZX, keep=NegativeOnly) in RelativeCS1
  magnet_1 [Magnet_S_NdFe31], magnet_2 [Magnet_N_NdFe30], magnet_3 [Magnet_S_NdFe31] = magnet.duplicate_around_axis(axis=Z, angle=90deg, total=4)
  Circle1 = circle(normal=Z, centre=(0mm, 0mm, 0mm), radius=105mm)
  stator_solid [iron] = circle(normal=Z, centre=(0mm, 0mm, 0mm), radius=120mm)
  stator_solid.subtract(Circle1)
  Circle2 [vacuum] = circle(normal=Z, centre=(0mm, 0mm, 0mm), radius=350mm)
  magnet_4 = magnet.copy()
  magnet_1_1 = magnet_1.copy()
  magnet_2_1 = magnet_2.copy()
  magnet_3_1 = magnet_3.copy()
  rotor_2 = rotor.copy()
  stator_solid_1 = stator_solid.copy()
  Circle2.subtract(magnet_4, magnet_1_1, magnet_2_1, magnet_3_1, rotor_2, stator_solid_1)
mesh:
  initial mesh: MeshMethod=AnsoftTAU
